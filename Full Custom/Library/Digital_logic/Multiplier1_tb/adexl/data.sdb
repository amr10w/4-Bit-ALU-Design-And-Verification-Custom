ADE simulation setup
Run mode: Single Run, Sweeps and Corners
Tests:
  Digital_logic:Multiplier1_tb:1: Digital_logic/Multiplier1_tb/schematic, simulator spectre
